envSetVal("asimenv.startup" "projectDir" 'string "./simulation")
simulator( 'hspiceD )
design("ece720t7" "torus_xbar_1b" "schematic")
modelFile(
    '("/CMC/kits/tsmc_65nm/CRN65GP/TN65CMSP018K3_V1.0C/tsmcN65/../models/hspice/crn65gplus_2d5_lk_v1d0.l" "tt")
)
envOption(
        'setTopLevelAsSubckt  t
)
createNetlist(?recreateAll t)
exit
~
