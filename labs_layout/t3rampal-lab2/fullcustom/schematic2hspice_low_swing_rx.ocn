envSetVal("asimenv.startup" "projectDir" 'string "./simulation")
simulator( 'hspiceD )
design("ece720t7" "low_swing_rx" "schematic")
modelFile(
    '("/CMC/kits/tsmc_65nm/CRN65GP/TN65CMSP018K3_V1.0C/tsmcN65/../models/hspice/crn65gplus_2d5_lk_v1d0.l" "tt")
    '("/CMC/kits/tsmc_65nm/CRN65GP/TN65CMSP018K3_V1.0C/tsmcN65/../models/hspice/crn65gplus_2d5_lk_v1d0.l" "tt_hvt")
)
envOption(
        'setTopLevelAsSubckt  t
)
createNetlist(?recreateAll t)
exit
~
